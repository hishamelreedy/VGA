ADE simulation setup
Run mode: Single Run, Sweeps and Corners
Tests:
  cuaic:ass1_var:1: cuaic/ass1_var/schematic, simulator spectre
    Outputs: pv("C0.cgate" "cap")
Global variables:
  corner = "tt_mim"
  corner1 = "tt_mos_cap"
  corner2 = "tt_rtmom"
Corners:
  SS: corner="ss_mim"; corner1="ss_mos_cap"; corner2="ss_rtmom"
  FF: corner="ff_mim"; corner1="ff_mos_cap"; corner2="ff_rtmom"
