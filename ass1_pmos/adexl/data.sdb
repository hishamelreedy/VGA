ADE simulation setup
Run mode: Single Run, Sweeps and Corners
Tests:
  cuaic:ass1_pmos:1: cuaic/ass1_pmos/schematic, simulator spectre
Global variables:
  vds = 0.2:0.1:0.8
