ADE simulation setup
Run mode: Single Run, Sweeps and Corners
Tests:
  cuaic:ass2_prt2:1 (off): cuaic/ass2_prt2/schematic, simulator spectre
  cuaic:ass2_prt2:2: cuaic/ass2_prt2/schematic, simulator spectre
Global variables:
  vb = 100m:100m:1 (off)
  vb3 = 100m:100m:1 (off)
  vb4 = 100m:100m:1 (off)
