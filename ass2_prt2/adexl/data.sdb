ADE simulation setup
Run mode: Single Run, Sweeps and Corners
Tests:
  cuaic:ass2_prt2:1: cuaic/ass2_prt2/schematic, simulator spectre
