ADE simulation setup
Run mode: Single Run, Sweeps and Corners
Tests:
  cuaic:Assignment2_mos_amp_matching:1 (off): cuaic/Assignment2_mos_amp_matching/schematic, simulator spectre
  cuaic:Assignment2_mos_amp_matching:2: cuaic/Assignment2_mos_amp_matching/schematic, simulator spectre
Global variables:
  VGS = .8
  CI = 80f
  LI = 5n
  CL = 78f
  LL = 5n
