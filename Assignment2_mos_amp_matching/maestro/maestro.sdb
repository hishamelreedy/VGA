ADE simulation setup
Run mode: Single Run, Sweeps and Corners
Tests:
  s-param (off): cuaic/Assignment2_mos_amp_matching/schematic, simulator spectre
    Variables: VGS = 0.25:0.05:1.2
    Outputs: norm_W_MAX1; norm_G_MAX1
  ind_degen (off): cuaic/Assignment2_mos_amp_matching/schematic, simulator spectre
    Outputs: ind_W_MAX1; ind_G_MAX1
  cap_res_FB (off): cuaic/Assignment2_mos_amp_matching/schematic, simulator spectre
    Outputs: rcfb_W_MAX1; rcfb_G_MAX1
  cascode (off): cuaic/Assignment2_mos_amp_matching/schematic, simulator spectre
    Outputs: cascode_W_MAX1; cascode_G_MAX1
  cuaic:Assignment2_mos_amp_matching:1: cuaic/Assignment2_mos_amp_matching/schematic, simulator spectre
    Variables: VGS = .95
Global variables:
  VGS = 0.95
