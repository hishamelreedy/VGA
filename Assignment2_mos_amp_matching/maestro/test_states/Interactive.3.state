ADE simulation setup
Test s-param: cuaic/Assignment2_mos_amp_matching/schematic, simulator spectre
  Models: /home/cadence/tsmc65/tsmcN65/../models/spectre/toplevel.scs[tt_lib], /home/cadence/savemos.sp
  Variables: VGS = 0.25:0.05:1.2
  Temperature: 27
  Analysis sp: start=1M stop=1000G ports=("/PORT0" "/PORT1")
  Output W_MAX = cross(db10(gmax(sp(1 1 ?result "sp") sp(1 2 ?result "sp") sp(2 1 ?result "sp") sp(2 2 ?result "sp"))) 0 1 "either" nil nil) (unticked)
  Output G_MAX = db10(gmax(sp(1 1 ?result "sp") sp(1 2 ?result "sp") sp(2 1 ?result "sp") sp(2 2 ?result "sp"))) (unticked)
  Output G_MSG = db10(gmsg(sp(1 1 ?result "sp") sp(1 2 ?result "sp") sp(2 1 ?result "sp") sp(2 2 ?result "sp"))) (unticked)
  Output Kf = kf(sp(1 1 ?result "sp") sp(1 2 ?result "sp") sp(2 1 ?result "sp") sp(2 2 ?result "sp")) (unticked)
  Output norm_W_MAX1 = cross(db10(gmax(sp(1 1 ?result "sp") sp(1 2 ?result "sp") sp(2 1 ?result "sp") sp(2 2 ?result "sp"))) 0 1 "either" nil nil)
  Output norm_G_MAX1 = db10(gmax(sp(1 1 ?result "sp") sp(1 2 ?result "sp") sp(2 1 ?result "sp") sp(2 2 ?result "sp")))
  Output norm_G_MSG1 = db10(gmsg(sp(1 1 ?result "sp") sp(1 2 ?result "sp") sp(2 1 ?result "sp") sp(2 2 ?result "sp")))
  Output norm_Kf 1 = kf(sp(1 1 ?result "sp") sp(1 2 ?result "sp") sp(2 1 ?result "sp") sp(2 2 ?result "sp"))
Test ind_degen: cuaic/Assignment2_mos_amp_matching/schematic, simulator spectre
  Models: /home/cadence/tsmc65/tsmcN65/../models/spectre/toplevel.scs[tt_lib]
  Temperature: 27
  Analysis sp: start=10M stop=1000G ports=("/PORT2" "/PORT3")
  Output ind_W_MAX1 = cross(db10(gmax(sp(1 1 ?result "sp") sp(1 2 ?result "sp") sp(2 1 ?result "sp") sp(2 2 ?result "sp"))) 0 1 "either" nil nil)
  Output ind_G_MAX1 = db10(gmax(sp(1 1 ?result "sp") sp(1 2 ?result "sp") sp(2 1 ?result "sp") sp(2 2 ?result "sp")))
  Output ind_G_MSG1 = db10(gmsg(sp(1 1 ?result "sp") sp(1 2 ?result "sp") sp(2 1 ?result "sp") sp(2 2 ?result "sp")))
  Output ind_Kf 1 = kf(sp(1 1 ?result "sp") sp(1 2 ?result "sp") sp(2 1 ?result "sp") sp(2 2 ?result "sp"))
Test cap_res_FB: cuaic/Assignment2_mos_amp_matching/schematic, simulator spectre
  Models: /home/cadence/tsmc65/tsmcN65/../models/spectre/toplevel.scs[tt_lib]
  Temperature: 27
  Analysis sp: start=10M stop=1000G ports=("/PORT4" "/PORT5")
  Output rcfb_W_MAX1 = cross(db10(gmax(sp(1 1 ?result "sp") sp(1 2 ?result "sp") sp(2 1 ?result "sp") sp(2 2 ?result "sp"))) 0 1 "either" nil nil)
  Output rcfb_G_MAX1 = db10(gmax(sp(1 1 ?result "sp") sp(1 2 ?result "sp") sp(2 1 ?result "sp") sp(2 2 ?result "sp")))
  Output rcfb_G_MSG1 = db10(gmsg(sp(1 1 ?result "sp") sp(1 2 ?result "sp") sp(2 1 ?result "sp") sp(2 2 ?result "sp")))
  Output rcfb_Kf 1 = kf(sp(1 1 ?result "sp") sp(1 2 ?result "sp") sp(2 1 ?result "sp") sp(2 2 ?result "sp"))
Test cascode: cuaic/Assignment2_mos_amp_matching/schematic, simulator spectre
  Models: /home/cadence/tsmc65/tsmcN65/../models/spectre/toplevel.scs[tt_lib]
  Temperature: 27
  Analysis sp: start=10M stop=1000G ports=("/PORT6" "/PORT7")
  Output cascode_W_MAX1 = cross(db10(gmax(sp(1 1 ?result "sp") sp(1 2 ?result "sp") sp(2 1 ?result "sp") sp(2 2 ?result "sp"))) 0 1 "either" nil nil)
  Output cascode_G_MAX1 = db10(gmax(sp(1 1 ?result "sp") sp(1 2 ?result "sp") sp(2 1 ?result "sp") sp(2 2 ?result "sp")))
  Output cascode_G_MSG1 = db10(gmsg(sp(1 1 ?result "sp") sp(1 2 ?result "sp") sp(2 1 ?result "sp") sp(2 2 ?result "sp")))
  Output cascode_Kf 1 = kf(sp(1 1 ?result "sp") sp(1 2 ?result "sp") sp(2 1 ?result "sp") sp(2 2 ?result "sp"))
