ADE simulation setup
Test s-param: cuaic/Assignment2_mos_amp_matching/schematic, simulator spectre
  Models: /home/cadence/tsmc65/tsmcN65/../models/spectre/toplevel.scs[tt_lib], /home/cadence/savemos.sp
  Variables: VGS = 0.25:0.05:1.2
  Temperature: 27
  Analysis sp: start=1M stop=1000G ports=("/PORT0" "/PORT1")
  Output norm_W_MAX1 = cross(db10(gmax(sp(1 1 ?result "sp") sp(1 2 ?result "sp") sp(2 1 ?result "sp") sp(2 2 ?result "sp"))) 0 1 "either" nil nil)
  Output norm_G_MAX1 = db10(gmax(sp(1 1 ?result "sp") sp(1 2 ?result "sp") sp(2 1 ?result "sp") sp(2 2 ?result "sp")))
  Output norm_G_MSG1 = db10(gmsg(sp(1 1 ?result "sp") sp(1 2 ?result "sp") sp(2 1 ?result "sp") sp(2 2 ?result "sp")))
  Output norm_Kf 1 = kf(sp(1 1 ?result "sp") sp(1 2 ?result "sp") sp(2 1 ?result "sp") sp(2 2 ?result "sp"))
  Output norm_LSB = lsb(sp(1 1 ?result "sp") sp(1 2 ?result "sp") sp(2 1 ?result "sp") sp(2 2 ?result "sp") '(8e+09 8e+09 8e+09))
  Output norm_SSB = ssb(sp(1 1 ?result "sp") sp(1 2 ?result "sp") sp(2 1 ?result "sp") sp(2 2 ?result "sp") '(8e+09 8e+09 8e+09))
  Output GAC freq=8e+09 = gac(sp(1 1 ?result "sp") sp(1 2 ?result "sp") sp(2 1 ?result "sp") sp(2 2 ?result "sp") '(0.0 10.0 20.0) '8e+09)
  Output GPC freq=8e+09 = gpc(sp(1 1 ?result "sp") sp(1 2 ?result "sp") sp(2 1 ?result "sp") sp(2 2 ?result "sp") '(0.0 10.0 20.0) '8e+09)
Test ind_degen: cuaic/Assignment2_mos_amp_matching/schematic, simulator spectre
  Models: /home/cadence/tsmc65/tsmcN65/../models/spectre/toplevel.scs[tt_lib]
  Temperature: 27
  Analysis sp: start=10M stop=1000G ports=("/PORT2" "/PORT3")
  Output ind_W_MAX1 = cross(db10(gmax(sp(1 1 ?result "sp") sp(1 2 ?result "sp") sp(2 1 ?result "sp") sp(2 2 ?result "sp"))) 0 1 "either" nil nil)
  Output ind_G_MAX1 = db10(gmax(sp(1 1 ?result "sp") sp(1 2 ?result "sp") sp(2 1 ?result "sp") sp(2 2 ?result "sp")))
  Output ind_G_MSG1 = db10(gmsg(sp(1 1 ?result "sp") sp(1 2 ?result "sp") sp(2 1 ?result "sp") sp(2 2 ?result "sp")))
  Output ind_Kf 1 = kf(sp(1 1 ?result "sp") sp(1 2 ?result "sp") sp(2 1 ?result "sp") sp(2 2 ?result "sp"))
  Output ind_LSB = lsb(sp(1 1 ?result "sp") sp(1 2 ?result "sp") sp(2 1 ?result "sp") sp(2 2 ?result "sp") '(8e+09 8e+09 8e+09))
  Output ind_SSB = ssb(sp(1 1 ?result "sp") sp(1 2 ?result "sp") sp(2 1 ?result "sp") sp(2 2 ?result "sp") '(8e+09 8e+09 8e+09))
  Output GAC freq=8e+09 = gac(sp(1 1 ?result "sp") sp(1 2 ?result "sp") sp(2 1 ?result "sp") sp(2 2 ?result "sp") '(0.0 10.0 20.0) '8e+09)
  Output GPC freq=8e+09 = gpc(sp(1 1 ?result "sp") sp(1 2 ?result "sp") sp(2 1 ?result "sp") sp(2 2 ?result "sp") '(0.0 10.0 20.0) '8e+09)
Test cap_res_FB: cuaic/Assignment2_mos_amp_matching/schematic, simulator spectre
  Models: /home/cadence/tsmc65/tsmcN65/../models/spectre/toplevel.scs[tt_lib]
  Temperature: 27
  Analysis sp: start=10M stop=1000G ports=("/PORT4" "/PORT5")
  Output rcfb_W_MAX1 = cross(db10(gmax(sp(1 1 ?result "sp") sp(1 2 ?result "sp") sp(2 1 ?result "sp") sp(2 2 ?result "sp"))) 0 1 "either" nil nil)
  Output rcfb_G_MAX1 = db10(gmax(sp(1 1 ?result "sp") sp(1 2 ?result "sp") sp(2 1 ?result "sp") sp(2 2 ?result "sp")))
  Output rcfb_G_MSG1 = db10(gmsg(sp(1 1 ?result "sp") sp(1 2 ?result "sp") sp(2 1 ?result "sp") sp(2 2 ?result "sp")))
  Output rcfb_Kf 1 = kf(sp(1 1 ?result "sp") sp(1 2 ?result "sp") sp(2 1 ?result "sp") sp(2 2 ?result "sp"))
  Output rcfb_LSB = lsb(sp(1 1 ?result "sp") sp(1 2 ?result "sp") sp(2 1 ?result "sp") sp(2 2 ?result "sp") '(8e+09 8e+09 8e+09))
  Output rcfb_SSB = ssb(sp(1 1 ?result "sp") sp(1 2 ?result "sp") sp(2 1 ?result "sp") sp(2 2 ?result "sp") '(8e+09 8e+09 8e+09))
  Output GAC freq=8e+09 = gac(sp(1 1 ?result "sp") sp(1 2 ?result "sp") sp(2 1 ?result "sp") sp(2 2 ?result "sp") '(0.0 10.0 20.0) '8e+09)
  Output GPC freq=8e+09 = gpc(sp(1 1 ?result "sp") sp(1 2 ?result "sp") sp(2 1 ?result "sp") sp(2 2 ?result "sp") '(0.0 10.0 20.0) '8e+09)
Test cascode: cuaic/Assignment2_mos_amp_matching/schematic, simulator spectre
  Models: /home/cadence/tsmc65/tsmcN65/../models/spectre/toplevel.scs[tt_lib]
  Temperature: 27
  Analysis sp: start=10M stop=1000G ports=("/PORT6" "/PORT7")
  Output cascode_W_MAX1 = cross(db10(gmax(sp(1 1 ?result "sp") sp(1 2 ?result "sp") sp(2 1 ?result "sp") sp(2 2 ?result "sp"))) 0 1 "either" nil nil)
  Output cascode_G_MAX1 = db10(gmax(sp(1 1 ?result "sp") sp(1 2 ?result "sp") sp(2 1 ?result "sp") sp(2 2 ?result "sp")))
  Output cascode_G_MSG1 = db10(gmsg(sp(1 1 ?result "sp") sp(1 2 ?result "sp") sp(2 1 ?result "sp") sp(2 2 ?result "sp")))
  Output cascode_Kf 1 = kf(sp(1 1 ?result "sp") sp(1 2 ?result "sp") sp(2 1 ?result "sp") sp(2 2 ?result "sp"))
  Output cascode_LSB = lsb(sp(1 1 ?result "sp") sp(1 2 ?result "sp") sp(2 1 ?result "sp") sp(2 2 ?result "sp") '(8e+09 8e+09 8e+09))
  Output cascode_SSB = ssb(sp(1 1 ?result "sp") sp(1 2 ?result "sp") sp(2 1 ?result "sp") sp(2 2 ?result "sp") '(8e+09 8e+09 8e+09))
  Output GPC freq=8e+09 = gpc(sp(1 1 ?result "sp") sp(1 2 ?result "sp") sp(2 1 ?result "sp") sp(2 2 ?result "sp") '(0.0 10.0 20.0) '8e+09)
  Output GAC freq=8e+09 = gac(sp(1 1 ?result "sp") sp(1 2 ?result "sp") sp(2 1 ?result "sp") sp(2 2 ?result "sp") '(0.0 10.0 20.0) '8e+09)
Test cuaic:Assignment2_mos_amp_matching:1: cuaic/Assignment2_mos_amp_matching/schematic, simulator spectre
  Models: /home/cadence/tsmc65/tsmcN65/../models/spectre/toplevel.scs[tt_lib]
  Variables: VGS = .95
  Temperature: 27
  Analysis sp: sweep none ports=("/PORT0" "/PORT1") freq=8G
Run mode: Single Run, Sweeps and Corners
Global variables:
  VGS = 0.95
Disabled tests: cap_res_FB, cascode, ind_degen, s-param
