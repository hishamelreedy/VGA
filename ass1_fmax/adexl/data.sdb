ADE simulation setup
Run mode: Single Run, Sweeps and Corners
Tests:
  THIN (off): cuaic/ass1_fmax/schematic, simulator spectre
  cuaic:ass1_fmax:2: cuaic/ass1_fmax/schematic, simulator spectre
Global variables:
  n_Lmin = 1
  NOF = 1
  W_L = 2
