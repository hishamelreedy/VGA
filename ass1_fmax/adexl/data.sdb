ADE simulation setup
Run mode: Single Run, Sweeps and Corners
Tests:
  THIN: cuaic/ass1_fmax/schematic, simulator spectre
  THICK (off): cuaic/ass1_fmax/schematic, simulator spectre
Global variables:
  NF = 1:2:10
  wl = 2:1:10 (off)
