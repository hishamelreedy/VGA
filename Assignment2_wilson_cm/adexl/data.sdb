ADE simulation setup
Run mode: Single Run, Sweeps and Corners
Tests:
  cuaic:Assignment2_wilson_cm:1: cuaic/Assignment2_wilson_cm/schematic, simulator spectre
    Outputs: R_OUT; i_out_err
Global variables (all switched off):
  F1 = 2
  F2 = 4
  F3 = 4
  F4 = 8
  L1 = 120n
  L2 = 60n
  L3 = 60n
  L4 = 60n
  VCOMB = 0.3
  VDD = 1.2
  W1 = 20*60n
  W2 = 20*60n
  W3 = 10*60n
  W4 = 20*60n
