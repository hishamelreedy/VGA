ADE simulation setup
Run mode: Single Run, Sweeps and Corners
Tests:
  cuaic:ass2_prt2_2:1: cuaic/ass2_prt2_2/schematic, simulator spectre
Global variables:
  vb = 200m:100m:1000m (off)
  M = 2
