ADE simulation setup
Run mode: Single Run, Sweeps and Corners
Tests:
  cuaic:ass1_res:1: cuaic/ass1_res/schematic, simulator spectre
    Outputs: (VS("/net1") / IS("/V0/MINUS")); rnpoly; rnod; rnpolywo; rnodwo; rnwsti; rnwod
Global variables:
  PC = "tt_res" (off)
Corners:
  FF: PC="ff_res"
  SS: PC="ss_res"
