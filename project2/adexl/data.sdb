ADE simulation setup
Run mode: Single Run, Sweeps and Corners
Tests:
  cuaic:project2:1: cuaic/project2/schematic, simulator spectre
    Outputs: (VF("/vop") - VF("/von")); phaseMargin((VF("/vop1") - VF("/von1"))); (VF("/vop1") - VF("/von1")); dB20((VF("/vop1") - VF("/von1"))); dB20((VF("/vop") - VF("/von")))
  cuaic:project2:2 (off): cuaic/project2/schematic, simulator spectre
Global variables:
  L = 0.5u:0.2u:2u (off)
  VDS = 0.4 (off)
  W = 100u:20u:200u (off)
  vb = 250m:50m:500m (off)
