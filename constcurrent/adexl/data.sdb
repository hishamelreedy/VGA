ADE simulation setup
Run mode: Single Run, Sweeps and Corners
Tests:
  cuaic:constcurrent:1: cuaic/constcurrent/schematic, simulator spectre
    Outputs: IDC("/Vidc/PLUS")
  cuaic:constcurrent:2 (off): cuaic/constcurrent/schematic, simulator spectre
Global variables:
  vdd = 1.08,1.2,1.32
  CORNER = "tt","ss","ff","sf","fs"
Corners:
  mintemp: temperature=-40
  maxtemp: temperature=125
