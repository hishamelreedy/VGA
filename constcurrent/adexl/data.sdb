ADE simulation setup
Run mode: Single Run, Sweeps and Corners
Tests:
  cuaic:constcurrent:1 (off): cuaic/constcurrent/schematic, simulator spectre
  cuaic:constcurrent:2: cuaic/constcurrent/schematic, simulator spectre
