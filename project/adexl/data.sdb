ADE simulation setup
Run mode: Single Run, Sweeps and Corners
Tests:
  cuaic:project:1: cuaic/project/schematic, simulator spectre
    Outputs: (VF("/vop") - VF("/von")); (VF("/vip") - VF("/vin")); (VF("/vomp") - VF("/vomn")); (VF("/vmp") - VF("/vmn"))
