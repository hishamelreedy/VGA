ADE simulation setup
Run mode: Single Run, Sweeps and Corners
Tests:
  cuaic:ass1_3bs:1: cuaic/ass1_3bs/schematic, simulator spectre
    Outputs: ((VF("/vout") * IF("/R0/MINUS")) / (VF("/vg") * IF("/V0/MINUS")))
