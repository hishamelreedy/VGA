ADE simulation setup
Run mode: Single Run, Sweeps and Corners
Tests:
  cuaic:BGR:1: cuaic/BGR/schematic, simulator spectre
    Outputs: ymax(mag((VF("/vcomp") / IF("/M3/D")))); average(mag(VS("/VREF"))); VDC("/VREF"); average(VDC("/VREF"))
Global variables:
  vdd = 1.08,1.2,1.32
  corner = "tt","ss","ff","sf","fs"
  sigma = 5 (off)
Corners:
  mintemp: temperature=-40
  maxtemp: temperature=125
