ADE simulation setup
Run mode: Monte Carlo Sampling
Tests:
  cuaic:BGR:1: cuaic/BGR/schematic, simulator spectre
    Outputs: ymax(mag((VF("/vcomp") / IF("/M3/D")))); average(mag(VS("/VREF"))); VDC("/VREF"); average(VDC("/VREF"))
Global variables:
  corner = "tt","ss","ff","sf","fs" (off)
  sigma = 5 (off)
Monte Carlo Sampling options: mcmethod=all, mcnumpoints=400
