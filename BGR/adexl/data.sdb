ADE simulation setup
Run mode: Single Run, Sweeps and Corners
Tests:
  cuaic:BGR:1: cuaic/BGR/schematic, simulator spectre
