ADE simulation setup
Run mode: Single Run, Sweeps and Corners
Tests:
  cuaic:vga2:1: cuaic/vga2/schematic, simulator spectre
    Outputs: (VT("/vop") - VT("/von")); (VT("/vip") - VT("/vin")); VF("/VREF"); VF("/vref"); VF("/vcm"); VF("/I0/vref"); VF("/I0/vcm")
  cuaic:vga2:2 (off): cuaic/vga2/schematic, simulator spectre
Global variables:
  L = 1u:0.1u:2u (off)
  VDS = 0.6
  VGS = 1.2
  W = 10u
