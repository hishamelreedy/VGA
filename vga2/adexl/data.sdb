ADE simulation setup
Run mode: Single Run, Sweeps and Corners
Tests:
  STB (off): cuaic/vga2/schematic, simulator spectre
  cuaic:vga2:1: cuaic/vga2/schematic, simulator spectre
Global variables:
  L = 1u:0.1u:2u (off)
  VDS = 0.6
  VGS = 1.2
  W = 10u
