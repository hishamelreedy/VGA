ADE simulation setup
Run mode: Single Run, Sweeps and Corners
Tests:
  cuaic:vga:1 (off): cuaic/vga/schematic, simulator spectre
    Outputs: (VF("/VOUTP") - VF("/VOUTN"))
  cuaic:vga:2: cuaic/vga/schematic, simulator spectre
    Outputs: (VF("/VOUTP") - VF("/VOUTN"))
