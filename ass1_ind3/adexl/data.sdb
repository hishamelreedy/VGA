ADE simulation setup
Run mode: Single Run, Sweeps and Corners
Tests:
  cuaic:ass1_ind3:1: cuaic/ass1_ind3/schematic, simulator spectre
