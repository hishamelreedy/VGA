ADE simulation setup
Run mode: Single Run, Sweeps and Corners
Tests:
  cuaic:ass2:1: cuaic/ass2/schematic, simulator spectre
Global variables:
  Sigma = 3
