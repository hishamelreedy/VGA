ADE simulation setup
Run mode: Monte Carlo Sampling
Tests:
  cuaic:ass2:1: cuaic/ass2/schematic, simulator spectre
Global variables:
  Sigma = 3
Monte Carlo Sampling options: mcmethod=all, mcnumpoints=200
