ADE simulation setup
Run mode: Single Run, Sweeps and Corners
Tests:
  cuaic:ass1_ind_tb:1: cuaic/ass1_ind_tb/schematic, simulator spectre
