ADE simulation setup
Run mode: Single Run, Sweeps and Corners
Tests:
  cuaic:ass1:1: cuaic/ass1/schematic, simulator spectre
Global variables:
  L = Lmin,4*Lmin
  Lmin = 60n (off)
  L2 = L2min,4*L2min (off)
  L2min = 280n (off)
