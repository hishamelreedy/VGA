ADE simulation setup
Test cuaic:mosfet:1: cuaic/mosfet/schematic, simulator spectre
  Models: /home/cadence/tsmc65/tsmcN65/../models/spectre/toplevel.scs[tt_lib], /home/cadence/savemos.sp
  Variables: VDS = 0.6; VGS = 0.6; W = 10u
  Temperature: 27
  Analysis dc: sweep VGS start=0 stop=1.2 step=0.05
  Output P_gmoverid = getData("M0:gmoverid" ?result "dc")
  Output P_rout = getData("M0:rout" ?result "dc")
  Output P_vdsat = v("M0:vdsat" ?result "dc")
  Output P_gm = getData("M0:gm" ?result "dc")
  Output P_cdd = getData("M0:cdd" ?result "dc")
  Output P_cgg = getData("M0:cgg" ?result "dc")
  Output P_id = getData("M0:id" ?result "dc")
  Output N_cdd = getData("M1:cdd" ?result "dc")
  Output N_cgg = getData("M1:cgg" ?result "dc")
  Output N_gm = getData("M1:gm" ?result "dc")
  Output N_gmoverid = getData("M1:gmoverid" ?result "dc")
  Output N_id = getData("M1:id" ?result "dc")
  Output N_rout = getData("M1:rout" ?result "dc")
  Output N_vdsat = v("M1:vdsat" ?result "dc")
Test cuaic:OP_AMP:1: cuaic/OP_AMP/schematic, simulator spectre
  Models: /home/cadence/tsmc65/tsmcN65/../models/spectre/toplevel.scs[tt_lib], /home/cadence/savemos.sp
  Variables: F12 = 20; F34 = 300; FCM = 125
  Temperature: 27
  Analysis dc: (saves the operating point)
  Analysis ac: start=1 stop=10G
