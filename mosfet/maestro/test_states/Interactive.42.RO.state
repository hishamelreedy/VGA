ADE simulation setup
Test cuaic:mosfet:1: cuaic/mosfet/schematic, simulator spectre
  Models: /home/cadence/tsmc65/tsmcN65/../models/spectre/toplevel.scs[tt_lib], /home/cadence/savemos.sp
  Variables: VDS = 0.6; VGS = 0.6; W = 10u
  Temperature: 27
  Analysis dc: sweep VGS start=0 stop=1.2 step=0.05
  Output M0:gmoverid = getData("M0:gmoverid" ?result "dc")
  Output M0:rout = getData("M0:rout" ?result "dc")
  Output M0:vdsat = v("M0:vdsat" ?result "dc")
  Output M0:gm = getData("M0:gm" ?result "dc")
  Output M0:cdd = getData("M0:cdd" ?result "dc")
  Output M0:cgg = getData("M0:cgg" ?result "dc")
  Output M0:id = getData("M0:id" ?result "dc")
Test cuaic:OP_AMP:1: cuaic/OP_AMP/schematic, simulator spectre
  Models: /home/cadence/tsmc65/tsmcN65/../models/spectre/toplevel.scs[tt_lib], /home/cadence/savemos.sp
  Variables: F12 = 100; F34 = 40; FCM = 200
  Temperature: 27
  Analysis dc: (saves the operating point)
