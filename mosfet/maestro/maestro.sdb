ADE simulation setup
Run mode: Single Run, Sweeps and Corners
Tests:
  cuaic:mosfet:1 (off): cuaic/mosfet/schematic, simulator spectre
    Variables: L = 1u:1u:10u; VDS = 0.1:0.05:1; VGS = 0.6; W = 10u
    Outputs: N_cdd; N_cgg; N_gm; N_gmoverid; N_id; N_rout; N_vdsat; (VF("/VO3+") - VF("/VO3-")); (VF("/I3/VO+") - VF("/I3/VO-"))
  cuaic:OP_AMP:1 (off): cuaic/OP_AMP/schematic, simulator spectre
    Variables: F12 = 500; F34 = 1400; FCM = 491; L12 = 2u; L34 = 2u; LCM = 3u; FCS = 150; FCSL = 80
    Outputs: ((VDC("/VO2+") + VDC("/VO2-")) / 2); V_CM_OTA; A_5OTA; A_CS; A_OL; A_CL=(1/B)
  cuaic:mosfet:2 (off): cuaic/mosfet/schematic, simulator spectre
    Variables: ID = 50u; L = 0.1u:0.1u:2u; VDS = .6; VGS = .6; W = 10u
  TB_SEOTA (off): cuaic/TESTBENCH/schematic, simulator spectre
    Outputs: A_SEOTA; V_SEOTA; VS
  TB_DIFF_OPAMP (off): cuaic/TESTBENCH/schematic, simulator spectre
    Variables: RF = 20K; Cc = 100f; Rz = 1000; Rp = 2.5K; v_pulse = 50m; VICM = 600m
    Outputs: A_OL_opamp; A_S1_opamp; VCM_opamp; A_S2_opamp; A_S2_opamp1; A_TELE_only; A_CS_only; V_cs_CM; A_OPAMP_CL; A_TELE_CS; V_tele_CM
  VGA_diff_stb (off): cuaic/TESTBENCH/schematic, simulator spectre
    Variables: RF = 2*Rp, 4*Rp,8*Rp,16*Rp; Rp = 2.5K; v_pulse = 0; VICM = 600m
    Outputs: CMRR; PSRR; v /net074; ac dB20(V)
  VGA_comm_std (off): cuaic/TESTBENCH/schematic, simulator spectre
    Variables: RF = 2*Rp, 4*Rp,8*Rp,16*Rp; Rp = 2.5K; v_pulse = 0; VICM = 600m
  Trans_pulse (off): cuaic/TESTBENCH/schematic, simulator spectre
    Variables: RF = 2*Rp, 4*Rp,8*Rp,16*Rp; VICM = 600m; v_pulse = 50m; Rp = 2.5K; CF = 3; Rz = 1K
    Outputs: STEP_INPUT; STEP_RESPONSE
  OPAMP_CMRANGE (off): cuaic/TESTBENCH/schematic, simulator spectre
    Variables: RF = 2*Rp, 4*Rp,8*Rp,16*Rp; VICM = 400m:10m:800m
  Trans_Sin (off): cuaic/TESTBENCH/schematic, simulator spectre
    Variables: RF = 2*Rp, 4*Rp,8*Rp,16*Rp; VICM = .6; CF = 3; Rp = 2.5K; Rz = 1K; v_pulse = .05
    Outputs: se_out; THD_diff; THD_se; input; DFT_se; DFT_diff
  cuaic:TESTBENCH:1: cuaic/TESTBENCH/schematic, simulator spectre
    Variables: L = 60n; RF = 0; Rp = 0; v_pulse = 0; VICM = 0; W = 200n: 100n:10u
Specs:
  cuaic:OP_AMP:1 / ((VDC("/VO2+") + VDC("/VO2-")) / 2): range .585 to 0.615
