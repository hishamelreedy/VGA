ADE simulation setup
Test cuaic:mosfet:1: cuaic/mosfet/schematic, simulator spectre
  Models: /home/cadence/tsmc65/tsmcN65/../models/spectre/toplevel.scs[tt_lib], /home/cadence/savemos.sp
  Variables: VDS = 0.6; VGS = 0.6; W = 10u
  Temperature: 27
  Analysis dc: sweep VGS start=0 stop=1.2 step=0.05
  Output P_gmoverid = getData("M0:gmoverid" ?result "dc")
  Output P_rout = getData("M0:rout" ?result "dc")
  Output N_gmoverid = getData("M1:gmoverid" ?result "dc")
  Output N_id = getData("M1:id" ?result "dc")
  Output N_rout = getData("M1:rout" ?result "dc")
  Output N_vdsat = v("M1:vdsat" ?result "dc")
  Output P_vdsat = v("M0:vdsat" ?result "dc")
  Output P_gm = getData("M0:gm" ?result "dc")
  Output P_cdd = getData("M0:cdd" ?result "dc")
  Output P_cgg = getData("M0:cgg" ?result "dc")
  Output (VF("/VO3+") - VF("/VO3-"))
  Output P_id = getData("M0:id" ?result "dc")
  Output N_cdd = getData("M1:cdd" ?result "dc")
  Output N_cgg = getData("M1:cgg" ?result "dc")
  Output N_gm = getData("M1:gm" ?result "dc")
Test cuaic:OP_AMP:1: cuaic/OP_AMP/schematic, simulator spectre
  Models: /home/cadence/tsmc65/tsmcN65/../models/spectre/toplevel.scs[tt_lib], /home/cadence/savemos.sp
  Variables: FCS = 150; FCSL = 80; L12 = 2u; L34 = 2u; LCM = 3u; F12 = 500; F34 = 1400; FCM = 491
  Temperature: 27
  Analysis pz: p=/VO2+ n=/VO2- iprobe=/V0
  Analysis ac: start=1 stop=10G
  Analysis dc: (saves the operating point)
  Analysis stb: start=1 stop=100G probe=/I16 stbProbeMode=differential
  Output VDC("/VOCM")
  Output A_5OTA = ((VF("/VO+") - VF("/VO-")) / (VF("/VI+") - VF("/VI-")))
  Output A_CS = ((VF("/VO2+") - VF("/VO2-")) / (VF("/VO+") - VF("/VO-")))
  Output A_OL = ((VF("/VO2+") - VF("/VO2-")) / (VF("/VI+") - VF("/VI-")))
  Output A_CL=(1/B) = ((VF("/VO2+") - VF("/VO2-")) / (VF("/VS+") - VF("/VS-")))
  Output ((VDC("/VO2+") + VDC("/VO2-")) / 2)
  Output (VT("/VO2+") - VT("/VO2-"))
  Output (VT("/VO+") - VT("/VO-"))
  Output V_CM_OTA = ((VDC("/VO+") + VDC("/VO-")) / 2)
Test cuaic:mosfet:2: cuaic/mosfet/schematic, simulator spectre
  Models: /home/cadence/tsmc65/tsmcN65/../models/spectre/toplevel.scs[tt_lib], /home/cadence/savemos.sp
  Variables: ID = 50u; L = 0.1u:0.1u:2u; VDS = .6; VGS = .6; W = 10u
  Temperature: 27
  Analysis dc: sweep ID start=0 stop=1m (saves the operating point)
Test TB_SEOTA: cuaic/TESTBENCH/schematic, simulator spectre
  Models: /home/cadence/tsmc65/tsmcN65/../models/spectre/toplevel.scs[tt_lib], /home/cadence/savemos.sp
  Temperature: 27
  Analysis ac: start=1 stop=10G
  Analysis dc: (saves the operating point)
  Output A_SEOTA = (VF("/V_SEOTA") / (VF("/VS+") - VF("/VS-")))
  Output V_SEOTA = VF("/V_SEOTA")
  Output VS = (VF("/VS+") - VF("/VS-"))
  Output VO_CM = VDC("/V_SEOTA")
Test TB_DIFF_OPAMP: cuaic/TESTBENCH/schematic, simulator spectre
  Models: /home/cadence/tsmc65/tsmcN65/../models/spectre/toplevel.scs[tt_lib]
  Variables: Rz = 1000; Cc = 100f; Rp = 2.5K; v_pulse = 50m; VICM = 600m; RF = 20K
  Temperature: 27
  Analysis dc: (saves the operating point)
  Output A_OL_opamp = ((VF("/V_OPAMP+") - VF("/V_OPAMP-")) / (VF("/VS+") - VF("/VS-"))) (unticked)
  Output A_S1_opamp = ((VF("/I3/VO+") - VF("/I3/VO-")) / (VF("/VS+") - VF("/VS-"))) (unticked)
  Output A_TELE_only = ((VF("/I8/VO_TELE+") - VF("/I8/VO_TELE-")) / (VF("/I8/VI+") - VF("/I8/VI-")))
  Output A_CS_only = ((VF("/I8/VS2+") - VF("/I8/VS2-")) / (VF("/I8/VO_TELE+") - VF("/I8/VO_TELE-")))
  Output A_TELE_CS = ((VF("/I8/VS2+") - VF("/I8/VS2-")) / (VF("/I8/VI+") - VF("/I8/VI-")))
  Output A_OPAMP_CL = ((VF("/VO3+") - VF("/VO3-")) / (VF("/VS+") - VF("/VS-")))
  Output V_tele_CM = ((VDC("/I8/VO_TELE+") + VDC("/I8/VO_TELE-")) / 2)
  Output V_cs_CM = ((VDC("/I8/VS2+") + VDC("/I8/VS2-")) / 2)
  Output Loop Gain Phase = phaseDegUnwrapped(getData("loopGain" ?result "stb"))
  Output Loop Gain dB20 = db(mag(getData("loopGain" ?result "stb")))
  Output VCM_opamp = ((VDC("/V_OPAMP+") + VDC("/V_OPAMP-")) / 2) (unticked)
  Output VCM_S1_opamp = ((VDC("/I3/VO+") + VDC("/I3/VO-")) / 2) (unticked)
  Output A_S2_opamp = ((VF("/V_OPAMP+") - VF("/V_OPAMP-")) / (VF("/I3/VO+") - VF("/I3/VO-"))) (unticked)
  Output A_S2_opamp1 = ((VF("/V_OPAMP+") - VF("/V_OPAMP-")) / (VF("/VS+") - VF("/VS-"))) (unticked)
Test VGA_diff_stb: cuaic/TESTBENCH/schematic, simulator spectre
  Models: /home/cadence/tsmc65/tsmcN65/../models/spectre/toplevel.scs[tt_lib]
  Variables: Rp = 2.5K; v_pulse = 0; VICM = 600m; RF = 2*Rp, 4*Rp,8*Rp,16*Rp
  Temperature: 27
  Analysis dc: (saves the operating point)
  Output LoopGainPhase_DM = phaseDegUnwrapped(getData("loopGain" ?result "stb"))
  Output LoopGain_DM = db(mag(getData("loopGain" ?result "stb")))
  Output PHASE = phaseDegUnwrapped((vfreq('ac "/VO3+") - vfreq('ac "/VO3-")))
  Output PSRR = dB20((1 / VF("/net074")))
  Output v (/net074 /net047); ac dB20(V) = db((vfreq('ac "/net074") - vfreq('ac "/net047")))
  Output v (/net040 /net041); ac dB20(V) = db((vfreq('ac "/net040") - vfreq('ac "/net041")))
  Output v /net047; ac dB20(V) = db(vfreq('ac "/net047"))
  Output v /net074; ac dB20(V) = (- db(vfreq('ac "/net074")))
  Output PhaseMargin_DM = getData("phaseMargin" ?result "stb_margin")
  Output A_DM_opamp = db((vfreq('ac "/net074") - vfreq('ac "/net047")))
  Output A_CM_opamp = db(vfreq('ac "/net042"))
  Output CMRR = (db((vfreq('ac "/net074") - vfreq('ac "/net047"))) - db(vfreq('ac "/net041")))
  Output GAIN_CL = db((vfreq('ac "/VO3+") - vfreq('ac "/VO3-")))
Test VGA_comm_std: cuaic/TESTBENCH/schematic, simulator spectre
  Models: /home/cadence/tsmc65/tsmcN65/../models/spectre/toplevel.scs[tt_lib], /home/cadence/savemos.sp
  Variables: Rp = 2.5K; v_pulse = 0; VICM = 600m; RF = 2*Rp, 4*Rp,8*Rp,16*Rp
  Temperature: 27
  Output LoopGainPhase_CM = phaseDegUnwrapped(getData("loopGain" ?result "stb"))
  Output LoopGain_CM = db(mag(getData("loopGain" ?result "stb")))
  Output PhaseMargin_CM = getData("phaseMargin" ?result "stb_margin")
Test Trans_pulse: cuaic/TESTBENCH/schematic, simulator spectre
  Models: /home/cadence/tsmc65/tsmcN65/../models/spectre/toplevel.scs[tt_lib]
  Variables: Rz = 1K; CF = 3; v_pulse = 50m; VICM = 600m; Rp = 2.5K; RF = 2*Rp, 4*Rp,8*Rp,16*Rp
  Temperature: 27
  Analysis tran: stop=20u errpreset=conservative
  Analysis dc: (saves the operating point)
  Output STEP_RESPONSE1 = (VT("/VO3+") - VT("/VO3-"))
  Output STEP_INPUT = (5 * (VT("/VS+") - VT("/VS-")))
  Output STEP_INPUT1 = (VT("/VS+") - VT("/VS-"))
  Output STEP_RESPONSE = (1.05 * (VT("/VO3+") - VT("/VO3-")))
Test OPAMP_CMRANGE: cuaic/TESTBENCH/schematic, simulator spectre
  Models: /home/cadence/tsmc65/tsmcN65/../models/spectre/toplevel.scs[tt_lib]
  Variables: RF = 2*Rp, 4*Rp,8*Rp,16*Rp; VICM = 400m:10m:800m
  Temperature: 27
  Analysis ac: start=1 stop=1G
  Analysis dc: (saves the operating point)
  Output A_w = (VF("/net074") - VF("/net047"))
  Output BW = bandwidth((VF("/net074") - VF("/net047")) 3 "low")
  Output A_o = real(value((VF("/net074") - VF("/net047")) 1))
Test Trans_Sin: cuaic/TESTBENCH/schematic, simulator spectre
  Models: /home/cadence/tsmc65/tsmcN65/../models/spectre/toplevel.scs[tt_lib]
  Variables: CF = 3; Rp = 2.5K; Rz = 1K; v_pulse = .05; VICM = .6; RF = 2*Rp, 4*Rp,8*Rp,16*Rp
  Temperature: 27
  Analysis tran: stop=100u errpreset=moderate
  Output input = (VT("/VS+") - VT("/VS-"))
  Output diff_out = (VT("/VO3+") - VT("/VO3-"))
  Output se_out = VT("/VO3+")
  Output THD_diff = thd((VT("/VO3+") - VT("/VO3-")) 4e-05 4.1e-05 64 1000000)
  Output DFT_diff = dft((VT("/VO3+") - VT("/VO3-")) 4e-05 4.1e-05 64 "Rectangular" 1 "default" 1.0)
  Output DFT_se = dft(VT("/VO3+") 4e-05 4.1e-05 64 "Rectangular" 1 "default" 1.0)
  Output THD_se = thd(VT("/VO3+") 4e-05 4.1e-05 64 1000000)
Test cuaic:TESTBENCH:1: cuaic/TESTBENCH/schematic, simulator spectre
  Models: /home/cadence/tsmc65/tsmcN65/../models/spectre/toplevel.scs[tt_lib], /home/cadence/savemos.sp
  Variables: L = 60n; RF = 0; Rp = 0; v_pulse = 0; VICM = 0; W = 1u
  Temperature: 27
  Analysis dc: sweep L start=60n stop=W (saves the operating point)
Run mode: Single Run, Sweeps and Corners
Specs:
  cuaic:OP_AMP:1 / ((VDC("/VO2+") + VDC("/VO2-")) / 2): range .585 to 0.615
Setup values for test cuaic:mosfet:1: L = 1u:1u:10u; VDS = 0.1:0.05:1
Setup values for test cuaic:TESTBENCH:1: W = 200n: 100n:10u
Disabled tests: OPAMP_CMRANGE, TB_DIFF_OPAMP, TB_SEOTA, Trans_Sin, Trans_pulse, VGA_comm_std, VGA_diff_stb, cuaic:OP_AMP:1, cuaic:mosfet:1, cuaic:mosfet:2
