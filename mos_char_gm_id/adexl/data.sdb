ADE simulation setup
Run mode: Single Run, Sweeps and Corners
Tests:
  cuaic:mos_char_gm_id:1: cuaic/mos_char_gm_id/schematic, simulator spectre
Global variables:
  FIN = 1
  L = 60n
  L_T = 280n
  VDS = .6
  VDS_T = 1.25
  VGS = .8
  VGS_T = 1.5
  VSB = 0
  VSB_T = 0
  W_REF = 2.5u
  W_REF_T = 2.5u
