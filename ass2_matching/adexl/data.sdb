ADE simulation setup
Run mode: Single Run, Sweeps and Corners
Tests:
  cuaic:ass2_matching:1: cuaic/ass2_matching/schematic, simulator spectre
